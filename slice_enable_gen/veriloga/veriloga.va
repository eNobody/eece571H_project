// VerilogA for eece571H_project, slice_enable_gen, veriloga

`include "constants.vams"
`include "disciplines.vams"

module slice_enable_gen(inout Vdd, input clk, inout gnd, output [11:0] enable_out);
  electrical Vdd;
  electrical clk;
  electrical gnd;
  electrical [11:0] enable_out;

  parameter real vout = 1.0;
  parameter integer main_cursor_slices = 9;
  parameter integer post_cursor_slices = 3;
  parameter integer main_cursor_on = 6;
  parameter integer post_cursor_on = 2;
  parameter sweep_inc_cycles = 0;

  integer cycle = 0;
  integer out_val = 1;

  genvar i;

  analog begin
   if (sweep_inc_cycles == 0) begin //normal operation mode
     for (i = 0;i < main_cursor_slices; i = i+1) begin
       if (i < main_cursor_on) begin
          V(enable_out[i],gnd) <+ vout;
       end else begin
          V(enable_out[i],gnd) <+ 0;
       end
     end

     for (i = main_cursor_slices;i < main_cursor_slices+post_cursor_slices; i = i+1) begin
       if (i < main_cursor_slices+post_cursor_on) begin
          V(enable_out[i],gnd) <+ vout;
       end else begin
          V(enable_out[i],gnd) <+ 0;
       end
     end
   end
   else begin //sweep mode
      @(cross(V(clk,gnd)-V(Vdd,gnd)/2, +1)) begin
        cycle = cycle+1;
        if (cycle == sweep_inc_cycles) begin
          cycle = 0;
          out_val = out_val+1;
        end
      end

      for (i = 0;i < main_cursor_slices+post_cursor_slices; i = i+1) begin
        if (i < out_val)  begin
          V(enable_out[i],gnd) <+ vout;
       end else begin
          V(enable_out[i],gnd) <+ 0;
       end
      end
   end
  end

endmodule
